(defun ffiOpenLib (t_lib)
	(cond
        ((stringp t_lib)
		    (ipcWriteProcess (get SFFI 'cid) "open\n")
		    (cond
                ((eq (ipcReadProcess (get SFFI 'cid) (get SFFI 'timeout)) "open")
                    (ipcWriteProcess (get SFFI 'cid) (strcat t_lib "\n"))
                    (ipcReadProcess (get SFFI 'cid) (get SFFI 'timeout)))
                (t (error "FFI ERROR" "TRY RELOADING"))))
        (t (error "FFI - Expected arguemnt type string, got %s." (typep t_lib))))
)

(defun ffiDefun (t_libHandle t_fnName t_rType l_aTypes)
    (cond
        ((not (stringp t_libHandle))
            (error "FFI - t_libHandle has to be a string instead of %s" (typep t_libHandle)))
        ((not (stringp t_fnName))
            (error "FFI - t_fnName has to be a string instead of %s" (typep t_fnName)))
        ((not (stringp t_rType))
            (error "FFI - t_rType has to be a string instead of %s" (typep t_rType)))
        ((not (listp l_aTypes))
            (error "FFI - t_aTypes has to be a string instead of %s" (typep l_aTypes)))
        (t
            (let ((o_pid (get SFFI 'cid)) (n_timeout (get SFFI 'timeout)))
                (if (eq (hsrtWriteCid o_pid "prep\n") "func")
                    (if (eq (hsrtWriteCid o_pid (strcat t_fnName "\n")) "lib")
                        (if (eq (hsrtWriteCid o_pid (strcat t_libHandle "\n")) "rtype")
                            (if (eq (hsrtWriteCid o_pid (strcat t_rType "\n")) "numargs")
                                (if (eq (hsrtWriteCid
                                            o_pid
                                            (strcat (sprintf nil "%d" (length l_aTypes)) "\n"))
                                            "atype")
                                    (reduce
                                        (lambda (at res)
                                            (if (eq res "atype")
                                                (hsrtWriteCid o_pid (strcat at "\n"))
                                                (ipcReadProcess o_pid n_timeout)))
                                        "aType"
                                        l_aTypes)
                                    (error "FFI - atypes"))
                                (error "FFI - numargs"))
                            (error "FFI - rtype"))
                        (error "FFI - lib handle"))
                    (error "FFI - function name")))))
)

(defun ffiCallfun (t_fnHandle l_fnArgs)
    (cond
        ((not (stringp t_fnHandle))
            (error "t_fnHandle has to be a string instead of %s" (typep t_fnHandle)))
        ((not (listp l_fnArgs))
            (error "l_fnArgs has to be a string instead of %s" (typep l_fnArgs)))
        (t (let ((o_pid (get SFFI 'cid)) (n_timeout (get SFFI 'timeout)))
                (if (eq (hsrtWriteCid o_pid "call\n") "fun")
                    (if (eq (hsrtWriteCid o_pid (strcat t_fnHandle "\n")) "val")
                        (reduce
                            (lambda (val res)
                                (if (eq res "val")
                                    (hsrtWriteCid o_pid (strcat val "\n"))
                                    (ipcReadProcess o_pid n_timeout)))
                            "val"
                            l_fnArgs)
                        (error "FFI - arguments %l" l_fnArgs))
                    (error "FFI - calling function %s" t_fnHandle)))))
)

(defun ffiCloseLib (t_libHandle)
    (cond
        ((eq (ipcWaitForProcess (get SFFI 'cid)) t)
            (ipcWriteProcess (get SFFI 'cid) "")
            (ipcReadProcess (get SFFI 'cid)))
    (t (error "FFI - Resource Busy...")))
)

(define SFFI (list nil
    'cid (ipcSkillProcess (strcat (getShellEnvVar "FFIPATH") "/skillFFI"))
    'path (strcat (getShellEnvVar "FFIPATH") "/skillFFI")
    'timeout 4
    'ready "ffi ready"
))

(let ((ffiReady (ipcReadProcess (get SFFI 'cid) (get SFFI 'timeout))))
    (if (eq ffiReady (get SFFI 'ready))
        (printf "FFI - Up and running!\n")
        (error "FFI - Could not launch FFI!"))
)
