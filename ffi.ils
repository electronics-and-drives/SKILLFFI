(defun ffiOpenLib (t_lib)
	(cond
        ((stringp t_lib)
		    (ipcWriteProcess ffiCID "open\n")
		    (if (eq (ipcReadProcess ffiCID ffiTimeOut) "open")
                (let ()
                    (ipcWriteProcess ffiCID (strcat t_lib "\n"))
                    (ipcReadProcess ffiCID ffiTimeOut))
                (error "FFI ERROR" "TRY RELOADING")))
        (t (error "FFI - Expected arguemnt type string, got %s." (typep t_lib))))
)

(defun ffiDefun (t_libHandle t_fnName t_rType t_aTypes)
    (cond
        ((not (stringp t_libHandle))
            (error "FFI - t_libHandle has to be a string instead of %s" (typep t_libHandle)))
        ((not (stringp t_fnName))
            (error "FFI - t_fnName has to be a string instead of %s" (typep t_fnName)))
        ((not (stringp t_rType))
            (error "FFI - t_rType has to be a string instead of %s" (typep t_rType)))
        ((not (listp t_aTypes))
            (error "FFI - t_aTypes has to be a string instead of %s" (typep t_aTypes)))
        (t
		    (ipcWriteProcess ffiCID "prep\n")
            (if (eq (ipcReadProcess ffiCID ffiTimeOut) "func") then
                (ipcWriteProcess ffiCID (strcat fnName "\n"))
                (if (eq (ipcReadProcess ffiCID ffiTimeOut) "lib") then
                    (ipcWriteProcess ffiCID (strcat libHandle "\n"))
                    (if (eq (ipcReadProcess ffiCID ffiTimeOut) "rtype") then
                        (ipcWriteProcess ffiCID (strcat rType "\n"))
                        (if (eq (ipcReadProcess ffiCID ffiTimeOut) "numargs") then
                            (sprintf numargs "%d" (length aTypes))
                            (ipcWriteProcess ffiCID (strcat  numargs "\n"))
                            (while (neq aTypes nil)
                                (if (eq (ipcReadProcess ffiCID ffiTimeOut) "atype") then
                                    (ipcWriteProcess ffiCID (strcat (car aTypes) "\n"))
                                    (setq aTypes (cdr aTypes))
                                )
                            )
                            (ipcReadProcess ffiCID ffiTimeOut)
                        else
                            (error "FFI ERROR" "numargs")
                        )
                    else
                        (error "FFI ERROR" "rtype")
                    )
                else
                    (error "FFI ERROR" "lib handle")
                )
            else
                (error "FFI ERROR" "function name")
            )
        )
    )
)

(defun ffiCallfun (fnHandle fnArgs)
    (cond ((not (stringp fnHandle)) (error "fnHandle has to be a string instead of %s" (typep fnHandle)))
        ((not (listp fnArgs)) (error "fnArgs has to be a string instead of %s" (typep fnArgs)))
        (t
            (ipcWriteProcess ffiCID "call\n")
            (if (eq (ipcReadProcess ffiCID ffiTimeOut) "fun") then
                (ipcWriteProcess ffiCID (strcat fnHandle "\n"))
                (while (neq fnArgs nil)
                    (if (eq (ipcReadProcess ffiCID ffiTimeOut) "val") then
                        (setq fnarg (car fnArgs))
                        (if (not (stringp fnarg))
                            (sprintf fnarg "%n" fnarg)
                        )
                        (ipcWriteProcess ffiCID (strcat fnarg "\n"))
                        (setq fnArgs (cdr fnArgs))
                    )
                )
                (ipcReadProcess ffiCID ffiTimeOut)
            else
                (error "FFI ERROR" "calling the function")
            )
        )
    )
)

(defun ffiCloseLib (libHandle)
    (cond
        ((eq (ipcWaitForProcess ffiCID) t)
            (ipcWriteProcess ffiCID "")
            (ipcReadProcess ffiCID))
    (t (error "FFI - Resource Busy...")))
)

(define SFFI (list nil
    'cid (ipcSkillProcess (strcat (getShellEnvVar "FFIPATH") "/skillFFI"))
    'path (strcat (getShellEnvVar "FFIPATH") "/skillFFI")
    'timeout 4
    'ready "ffi ready"
))

(let ((ffiReady (ipcReadProcess ffiCID ffiTimeOut)))
    (if (eq ffiReady (get SFFI 'ready))
        (printf "FFI - Up and running!\n")
        (error "FFI - Could not launch FFI!"))
)
