(defun ffiOpenLib (t_lib)
	(cond
        ((stringp t_lib)
		    (ipcWriteProcess (get SFFI 'cid) "open\n")
		    (cond
                ((eq (ipcReadProcess (get SFFI 'cid) (get SFFI 'timeout)) "open")
                    (ipcWriteProcess (get SFFI 'cid) (strcat t_lib "\n"))
                    (ipcReadProcess (get SFFI 'cid) (get SFFI 'timeout)))
                (t (error "FFI ERROR" "TRY RELOADING")))
        (t (error "FFI - Expected arguemnt type string, got %s." (typep t_lib))))
)

(defun ffiDefun (t_libHandle t_fnName t_rType t_aTypes)
    (cond
        ((not (stringp t_libHandle))
            (error "FFI - t_libHandle has to be a string instead of %s" (typep t_libHandle)))
        ((not (stringp t_fnName))
            (error "FFI - t_fnName has to be a string instead of %s" (typep t_fnName)))
        ((not (stringp t_rType))
            (error "FFI - t_rType has to be a string instead of %s" (typep t_rType)))
        ((not (listp t_aTypes))
            (error "FFI - t_aTypes has to be a string instead of %s" (typep t_aTypes)))
        (t
		    (ipcWriteProcess (get SFFI 'cid) "prep\n")
            (if (eq (ipcReadProcess (get SFFI 'cid) (get SFFI 'timeout)) "func") then
                (ipcWriteProcess (get SFFI 'cid) (strcat fnName "\n"))
                (if (eq (ipcReadProcess (get SFFI 'cid) (get SFFI 'timeout)) "lib") then
                    (ipcWriteProcess (get SFFI 'cid) (strcat libHandle "\n"))
                    (if (eq (ipcReadProcess (get SFFI 'cid) (get SFFI 'timeout)) "rtype") then
                        (ipcWriteProcess (get SFFI 'cid) (strcat rType "\n"))
                        (if (eq (ipcReadProcess (get SFFI 'cid) (get SFFI 'timeout)) "numargs") then
                            (sprintf numargs "%d" (length aTypes))
                            (ipcWriteProcess (get SFFI 'cid) (strcat  numargs "\n"))
                            (while (neq aTypes nil)
                                (if (eq (ipcReadProcess (get SFFI 'cid) (get SFFI 'timeout)) "atype") then
                                    (ipcWriteProcess (get SFFI 'cid) (strcat (car aTypes) "\n"))
                                    (setq aTypes (cdr aTypes))
                                )
                            )
                            (ipcReadProcess (get SFFI 'cid) (get SFFI 'timeout))
                        else
                            (error "FFI ERROR" "numargs")
                        )
                    else
                        (error "FFI ERROR" "rtype")
                    )
                else
                    (error "FFI ERROR" "lib handle")
                )
            else
                (error "FFI ERROR" "function name")
            )
        )
    )
)

(defun ffiCallfun (fnHandle fnArgs)
    (cond ((not (stringp fnHandle)) (error "fnHandle has to be a string instead of %s" (typep fnHandle)))
        ((not (listp fnArgs)) (error "fnArgs has to be a string instead of %s" (typep fnArgs)))
        (t
            (ipcWriteProcess (get SFFI 'cid) "call\n")
            (if (eq (ipcReadProcess (get SFFI 'cid) (get SFFI 'timeout)) "fun") then
                (ipcWriteProcess (get SFFI 'cid) (strcat fnHandle "\n"))
                (while (neq fnArgs nil)
                    (if (eq (ipcReadProcess (get SFFI 'cid) (get SFFI 'timeout)) "val") then
                        (setq fnarg (car fnArgs))
                        (if (not (stringp fnarg))
                            (sprintf fnarg "%n" fnarg)
                        )
                        (ipcWriteProcess (get SFFI 'cid) (strcat fnarg "\n"))
                        (setq fnArgs (cdr fnArgs))
                    )
                )
                (ipcReadProcess (get SFFI 'cid) (get SFFI 'timeout))
            else
                (error "FFI ERROR" "calling the function")
            )
        )
    )
)

(defun ffiCloseLib (libHandle)
    (cond
        ((eq (ipcWaitForProcess (get SFFI 'cid)) t)
            (ipcWriteProcess (get SFFI 'cid) "")
            (ipcReadProcess (get SFFI 'cid)))
    (t (error "FFI - Resource Busy...")))
)

(define SFFI (list nil
    'cid (ipcSkillProcess (strcat (getShellEnvVar "FFIPATH") "/skillFFI"))
    'path (strcat (getShellEnvVar "FFIPATH") "/skillFFI")
    'timeout 4
    'ready "ffi ready"
))

(let ((ffiReady (ipcReadProcess (get SFFI 'cid) (get SFFI 'timeout))))
    (if (eq ffiReady (get SFFI 'ready))
        (printf "FFI - Up and running!\n")
        (error "FFI - Could not launch FFI!"))
)
